/*
 *  Revision and copyright information.
 *
 *  Copyright (c) 1998,1999
 *  by Bernd Abel
 *
 *  Permission to use, copy, modify, and distribute this software and
 *  its documentation for any usage and without fee is hereby granted,
 *  provided that the copyright notices appear in all copies and
 *  supporting documentation and that the author is properly credited.
 *  The author makes no representations as to the suitability of this
 *  software for any purpose.  It is provided `as is', without expressed
 *  or implied warranty.
 *
 *  The sparse package used in this library is copyrighted by Ken Kundert
 *  and the University of California, Berkeley. Please refer to the
 *  copyright notices in the files of the sparse directory.
 *
 *  $Date: 99/01/07$
 *  $Revision: 0.76$
 */

* Diode
.width out=80
.options limpts=10000

v1  1 0 dc 0
vd1 1 2 dc 0
d1  2 0 dmod
.model dmod d bv=5

.op
.dc v1 -5.4 1 0.01
.print dc i(vd1)

.end
